** sch_path: /foss/designs/PROJECTS/os-ina-pso-mixdes_2026/Xschem Simulations/FDDA_CMFB/tb_FDDA_CMFB_BIAS_ac.sch
**.subckt tb_FDDA_CMFB_BIAS_ac V_PP V_PN V_NP V_NN VDD V_OP V_ON VSS
*.ipin V_PP
*.ipin V_PN
*.ipin V_NP
*.ipin V_NN
*.iopin VDD
*.opin V_OP
*.opin V_ON
*.iopin VSS
XMP1 net3 V_PP V_C V_C sky130_fd_pr__pfet_01v8 L=L_1 W=W_1 nf=1 ad='int((1 + 1)/2) * W_1 / 1 * 0.29' as='int((1 + 2)/2) * W_1 / 1 * 0.29'
+ pd='2*int((1 + 1)/2) * (W_1 / 1 + 0.29)' ps='2*int((1 + 2)/2) * (W_1 / 1 + 0.29)' nrd='0.29 / W_1 ' nrs='0.29 / W_1 ' sa=0 sb=0 sd=0
+ mult=1 m=1
XMP2 V_B V_PN V_C V_C sky130_fd_pr__pfet_01v8 L=L_1 W=W_1 nf=1 ad='int((1 + 1)/2) * W_1 / 1 * 0.29' as='int((1 + 2)/2) * W_1 / 1 * 0.29'
+ pd='2*int((1 + 1)/2) * (W_1 / 1 + 0.29)' ps='2*int((1 + 2)/2) * (W_1 / 1 + 0.29)' nrd='0.29 / W_1 ' nrs='0.29 / W_1 ' sa=0 sb=0 sd=0
+ mult=1 m=1
XMP3 V_B V_NP net1 net1 sky130_fd_pr__pfet_01v8 L=L_1 W=W_1 nf=1 ad='int((1 + 1)/2) * W_1 / 1 * 0.29' as='int((1 + 2)/2) * W_1 / 1 * 0.29'
+ pd='2*int((1 + 1)/2) * (W_1 / 1 + 0.29)' ps='2*int((1 + 2)/2) * (W_1 / 1 + 0.29)' nrd='0.29 / W_1 ' nrs='0.29 / W_1 ' sa=0 sb=0 sd=0
+ mult=1 m=1
XMP4 net3 V_NN net1 net1 sky130_fd_pr__pfet_01v8 L=L_1 W=W_1 nf=1 ad='int((1 + 1)/2) * W_1 / 1 * 0.29' as='int((1 + 2)/2) * W_1 / 1 * 0.29'
+ pd='2*int((1 + 1)/2) * (W_1 / 1 + 0.29)' ps='2*int((1 + 2)/2) * (W_1 / 1 + 0.29)' nrd='0.29 / W_1 ' nrs='0.29 / W_1 ' sa=0 sb=0 sd=0
+ mult=1 m=1
XMP5 net2 V_CMFB VDD VDD sky130_fd_pr__pfet_01v8 L=L_2 W=W_2 nf=1 ad='int((1 + 1)/2) * W_2 / 1 * 0.29' as='int((1 + 2)/2) * W_2 / 1 * 0.29'
+ pd='2*int((1 + 1)/2) * (W_2 / 1 + 0.29)' ps='2*int((1 + 2)/2) * (W_2 / 1 + 0.29)' nrd='0.29 / W_2 ' nrs='0.29 / W_2 ' sa=0 sb=0 sd=0
+ mult=1 m=1
XMP6 V_A V_CMFB VDD VDD sky130_fd_pr__pfet_01v8 L=L_2 W=W_2 nf=1 ad='int((1 + 1)/2) * W_2 / 1 * 0.29' as='int((1 + 2)/2) * W_2 / 1 * 0.29'
+ pd='2*int((1 + 1)/2) * (W_2 / 1 + 0.29)' ps='2*int((1 + 2)/2) * (W_2 / 1 + 0.29)' nrd='0.29 / W_2 ' nrs='0.29 / W_2 ' sa=0 sb=0 sd=0
+ mult=1 m=1
XMP7 V_ON V_B4 net2 net2 sky130_fd_pr__pfet_01v8 L=L_3 W=W_3 nf=1 ad='int((1 + 1)/2) * W_3 / 1 * 0.29' as='int((1 + 2)/2) * W_3 / 1 * 0.29'
+ pd='2*int((1 + 1)/2) * (W_3 / 1 + 0.29)' ps='2*int((1 + 2)/2) * (W_3 / 1 + 0.29)' nrd='0.29 / W_3 ' nrs='0.29 / W_3 ' sa=0 sb=0 sd=0
+ mult=1 m=1
XMP8 V_OP V_B4 V_A V_A sky130_fd_pr__pfet_01v8 L=L_3 W=W_3 nf=1 ad='int((1 + 1)/2) * W_3 / 1 * 0.29' as='int((1 + 2)/2) * W_3 / 1 * 0.29'
+ pd='2*int((1 + 1)/2) * (W_3 / 1 + 0.29)' ps='2*int((1 + 2)/2) * (W_3 / 1 + 0.29)' nrd='0.29 / W_3 ' nrs='0.29 / W_3 ' sa=0 sb=0 sd=0
+ mult=1 m=1
XMP11 V_C V_B1 VDD VDD sky130_fd_pr__pfet_01v8 L=L_6 W=W_6 nf=1 ad='int((1 + 1)/2) * W_6 / 1 * 0.29' as='int((1 + 2)/2) * W_6 / 1 * 0.29'
+ pd='2*int((1 + 1)/2) * (W_6 / 1 + 0.29)' ps='2*int((1 + 2)/2) * (W_6 / 1 + 0.29)' nrd='0.29 / W_6 ' nrs='0.29 / W_6 ' sa=0 sb=0 sd=0
+ mult=1 m=1
XMP12 net1 V_B1 VDD VDD sky130_fd_pr__pfet_01v8 L=L_6 W=W_6 nf=1 ad='int((1 + 1)/2) * W_6 / 1 * 0.29' as='int((1 + 2)/2) * W_6 / 1 * 0.29'
+ pd='2*int((1 + 1)/2) * (W_6 / 1 + 0.29)' ps='2*int((1 + 2)/2) * (W_6 / 1 + 0.29)' nrd='0.29 / W_6 ' nrs='0.29 / W_6 ' sa=0 sb=0 sd=0
+ mult=1 m=1
XMN3 V_ON V_B3 net3 net3 sky130_fd_pr__nfet_01v8 L=L_4 W=W_4 nf=1 ad='int((1 + 1)/2) * W_4 / 1 * 0.29' as='int((1 + 2)/2) * W_4 / 1 * 0.29'
+ pd='2*int((1 + 1)/2) * (W_4 / 1 + 0.29)' ps='2*int((1 + 2)/2) * (W_4 / 1 + 0.29)' nrd='0.29 / W_4 ' nrs='0.29 / W_4 ' sa=0 sb=0 sd=0
+ mult=1 m=1
XMN4 V_OP V_B3 V_B V_B sky130_fd_pr__nfet_01v8 L=L_4 W=W_4 nf=1 ad='int((1 + 1)/2) * W_4 / 1 * 0.29' as='int((1 + 2)/2) * W_4 / 1 * 0.29'
+ pd='2*int((1 + 1)/2) * (W_4 / 1 + 0.29)' ps='2*int((1 + 2)/2) * (W_4 / 1 + 0.29)' nrd='0.29 / W_4 ' nrs='0.29 / W_4 ' sa=0 sb=0 sd=0
+ mult=1 m=1
XMN9 net3 V_B2 VSS VSS sky130_fd_pr__nfet_01v8 L=L_5 W=W_5 nf=1 ad='int((1 + 1)/2) * W_5 / 1 * 0.29' as='int((1 + 2)/2) * W_5 / 1 * 0.29'
+ pd='2*int((1 + 1)/2) * (W_5 / 1 + 0.29)' ps='2*int((1 + 2)/2) * (W_5 / 1 + 0.29)' nrd='0.29 / W_5 ' nrs='0.29 / W_5 ' sa=0 sb=0 sd=0
+ mult=1 m=1
XMN10 V_B V_B2 VSS VSS sky130_fd_pr__nfet_01v8 L=L_5 W=W_5 nf=1 ad='int((1 + 1)/2) * W_5 / 1 * 0.29' as='int((1 + 2)/2) * W_5 / 1 * 0.29'
+ pd='2*int((1 + 1)/2) * (W_5 / 1 + 0.29)' ps='2*int((1 + 2)/2) * (W_5 / 1 + 0.29)' nrd='0.29 / W_5 ' nrs='0.29 / W_5 ' sa=0 sb=0 sd=0
+ mult=1 m=1
XMN1 net4 V_OP net5 net5 sky130_fd_pr__nfet_01v8 L=L_7 W=W_7 nf=1 ad='int((1 + 1)/2) * W_7 / 1 * 0.29' as='int((1 + 2)/2) * W_7 / 1 * 0.29'
+ pd='2*int((1 + 1)/2) * (W_7 / 1 + 0.29)' ps='2*int((1 + 2)/2) * (W_7 / 1 + 0.29)' nrd='0.29 / W_7 ' nrs='0.29 / W_7 ' sa=0 sb=0 sd=0
+ mult=1 m=1
XMN2 V_CMFB V_CM net5 net5 sky130_fd_pr__nfet_01v8 L=L_7 W=W_7 nf=1 ad='int((1 + 1)/2) * W_7 / 1 * 0.29' as='int((1 + 2)/2) * W_7 / 1 * 0.29'
+ pd='2*int((1 + 1)/2) * (W_7 / 1 + 0.29)' ps='2*int((1 + 2)/2) * (W_7 / 1 + 0.29)' nrd='0.29 / W_7 ' nrs='0.29 / W_7 ' sa=0 sb=0 sd=0
+ mult=1 m=1
XMN7 net5 V_B2 VSS VSS sky130_fd_pr__nfet_01v8 L=L_5 W=W_5 nf=1 ad='int((1 + 1)/2) * W_5 / 1 * 0.29' as='int((1 + 2)/2) * W_5 / 1 * 0.29'
+ pd='2*int((1 + 1)/2) * (W_5 / 1 + 0.29)' ps='2*int((1 + 2)/2) * (W_5 / 1 + 0.29)' nrd='0.29 / W_5 ' nrs='0.29 / W_5 ' sa=0 sb=0 sd=0
+ mult=1 m=1
XMN6 net7 V_ON net6 net6 sky130_fd_pr__nfet_01v8 L=L_7 W=W_7 nf=1 ad='int((1 + 1)/2) * W_7 / 1 * 0.29' as='int((1 + 2)/2) * W_7 / 1 * 0.29'
+ pd='2*int((1 + 1)/2) * (W_7 / 1 + 0.29)' ps='2*int((1 + 2)/2) * (W_7 / 1 + 0.29)' nrd='0.29 / W_7 ' nrs='0.29 / W_7 ' sa=0 sb=0 sd=0
+ mult=1 m=1
XMN5 V_CMFB V_CM net6 net6 sky130_fd_pr__nfet_01v8 L=L_7 W=W_7 nf=1 ad='int((1 + 1)/2) * W_7 / 1 * 0.29' as='int((1 + 2)/2) * W_7 / 1 * 0.29'
+ pd='2*int((1 + 1)/2) * (W_7 / 1 + 0.29)' ps='2*int((1 + 2)/2) * (W_7 / 1 + 0.29)' nrd='0.29 / W_7 ' nrs='0.29 / W_7 ' sa=0 sb=0 sd=0
+ mult=1 m=1
XMN8 net6 V_B2 VSS VSS sky130_fd_pr__nfet_01v8 L=L_5 W=W_5 nf=1 ad='int((1 + 1)/2) * W_5 / 1 * 0.29' as='int((1 + 2)/2) * W_5 / 1 * 0.29'
+ pd='2*int((1 + 1)/2) * (W_5 / 1 + 0.29)' ps='2*int((1 + 2)/2) * (W_5 / 1 + 0.29)' nrd='0.29 / W_5 ' nrs='0.29 / W_5 ' sa=0 sb=0 sd=0
+ mult=1 m=1
XMP9 net4 net4 VDD VDD sky130_fd_pr__pfet_01v8 L=L_8 W=W_8/2 nf=1 ad='int((1 + 1)/2) * W_8/2 / 1 * 0.29' as='int((1 + 2)/2) * W_8/2 / 1 * 0.29'
+ pd='2*int((1 + 1)/2) * (W_8/2 / 1 + 0.29)' ps='2*int((1 + 2)/2) * (W_8/2 / 1 + 0.29)' nrd='0.29 / W_8/2 ' nrs='0.29 / W_8/2 ' sa=0
+ sb=0 sd=0 mult=1 m=1
XMP13 V_CMFB V_CMFB VDD VDD sky130_fd_pr__pfet_01v8 L=L_8 W=W_8 nf=1 ad='int((1 + 1)/2) * W_8 / 1 * 0.29' as='int((1 + 2)/2) * W_8 / 1 * 0.29'
+ pd='2*int((1 + 1)/2) * (W_8 / 1 + 0.29)' ps='2*int((1 + 2)/2) * (W_8 / 1 + 0.29)' nrd='0.29 / W_8 ' nrs='0.29 / W_8 ' sa=0 sb=0 sd=0
+ mult=1 m=1
XMP10 net7 net7 VDD VDD sky130_fd_pr__pfet_01v8 L=L_8 W=W_8/2 nf=1 ad='int((1 + 1)/2) * W_8/2 / 1 * 0.29' as='int((1 + 2)/2) * W_8/2 / 1 * 0.29'
+ pd='2*int((1 + 1)/2) * (W_8/2 / 1 + 0.29)' ps='2*int((1 + 2)/2) * (W_8/2 / 1 + 0.29)' nrd='0.29 / W_8/2 ' nrs='0.29 / W_8/2 ' sa=0
+ sb=0 sd=0 mult=1 m=1
V5 V_CM VSS 0.9
V10 V_PN GND DC 0.9 AC -0.5
V7 V_PP GND DC 0.9 AC 0.5
V8 VSS GND 0
V9 VDD GND 1.8
V6 V_NN GND DC 0.9 AC 0.5
V11 V_NP GND DC 0.9 AC -0.5
C1 V_ON GND 2p m=1
C2 V_OP GND 2p m=1
XMN11 net8 net8 VSS VSS sky130_fd_pr__nfet_01v8 L=2 W=5 nf=1 ad=1.45 as=1.45 pd=10.58 ps=10.58 nrd=0.058 nrs=0.058 sa=0 sb=0 sd=0
+ mult=1 m=1
XMP14 V_B1 V_B1 VDD VDD sky130_fd_pr__pfet_01v8 L=2 W=35 nf=1 ad=10.15 as=10.15 pd=70.58 ps=70.58 nrd=0.00828571428571429
+ nrs=0.00828571428571429 sa=0 sb=0 sd=0 mult=1 m=1
IREF VDD net8 2.5u
XMN12 V_B1 net8 VSS VSS sky130_fd_pr__nfet_01v8 L=2 W=5 nf=1 ad=1.45 as=1.45 pd=10.58 ps=10.58 nrd=0.058 nrs=0.058 sa=0 sb=0 sd=0
+ mult=1 m=1
XMP15 V_B3 V_B1 VDD VDD sky130_fd_pr__pfet_01v8 L=2 W=35 nf=1 ad=10.15 as=10.15 pd=70.58 ps=70.58 nrd=0.00828571428571429
+ nrs=0.00828571428571429 sa=0 sb=0 sd=0 mult=1 m=1
XMP16 V_B2 V_B1 VDD VDD sky130_fd_pr__pfet_01v8 L=2 W=35 nf=1 ad=10.15 as=10.15 pd=70.58 ps=70.58 nrd=0.00828571428571429
+ nrs=0.00828571428571429 sa=0 sb=0 sd=0 mult=1 m=1
XMN13 V_B3 V_B3 VSS VSS sky130_fd_pr__nfet_01v8 L=4 W=1 nf=1 ad=0.29 as=0.29 pd=2.58 ps=2.58 nrd=0.29 nrs=0.29 sa=0 sb=0 sd=0
+ mult=1 m=1
XMN14 V_B2 V_B2 VSS VSS sky130_fd_pr__nfet_01v8 L=2 W=5 nf=1 ad=1.45 as=1.45 pd=10.58 ps=10.58 nrd=0.058 nrs=0.058 sa=0 sb=0 sd=0
+ mult=1 m=1
XMN15 V_B4 V_B2 VSS VSS sky130_fd_pr__nfet_01v8 L=2 W=5 nf=1 ad=1.45 as=1.45 pd=10.58 ps=10.58 nrd=0.058 nrs=0.058 sa=0 sb=0 sd=0
+ mult=1 m=1
XMP17 V_B4 V_B4 VDD VDD sky130_fd_pr__pfet_01v8 L=3 W=5 nf=1 ad=1.45 as=1.45 pd=10.58 ps=10.58 nrd=0.058 nrs=0.058 sa=0 sb=0 sd=0
+ mult=1 m=1
**** begin user architecture code

** opencircuitdesign pdks install
.lib /foss/pdks/sky130A/libs.tech/combined/sky130.lib.spice tt

.control
  save all
  ac dec 20 0.1 1G

  let vout = v(v_op) - v(v_on)
  let vin = (v(v_pp) - v(v_pn)) - (v(v_np) - v(v_nn))

  let gain = vout / vin
  let db_gain = db(gain)
  let deg_phase = 180*cph(v(vout))/pi

  meas ac gain_DC FIND db_gain AT=1

  meas ac gbw_freq WHEN db_gain=0 FALL=1
  let gbw_Mfreq = gbw_freq * 1e-6

  meas ac pm_deg FIND deg_phase AT=gbw_freq
  let pm = 180 + pm_deg

  plot db_gain deg_phase
  print gain_DC
  print gbw_Mfreq
  print pm
.endc

.param temp=25
.option savecurrents
.param W_1=88
.param W_2=88
.param W_3=88
.param W_4=14
.param W_5=28
.param W_6=176
.param W_7=14
.param W_8=176
.param L_1=1
.param L_2=1
.param L_3=1
.param L_4=1
.param L_5=1
.param L_6=1
.param L_7=1
.param L_8=1
.control
  save all
  op
  write tb_FDDA_CMFB_BIAS_ac.raw
.endc

**** end user architecture code
**.ends
.GLOBAL GND
.end
