* 5T_OTA (Auto-Generated)
.subckt 5T_OTA VDD Vout Vin Vip VSS
XM1 Vx Vip Vc Vc sky130_fd_pr__nfet_01v8 L=0.7 W=2.53 nf=1 ad='int((1 + 1)/2) * 2.53 / 1 * 0.29' as='int((1 + 2)/2) * 2.53 / 1 * 0.29'
+ pd='2*int((1 + 1)/2) * (2.53 / 1 + 0.29)' ps='2*int((1 + 2)/2) * (2.53 / 1 + 0.29)' nrd='0.29 / 2.53 ' nrs='0.29 / 2.53 ' sa=0
+ sb=0 sd=0 mult=1 m=1
XM2 Vout Vin Vc Vc sky130_fd_pr__nfet_01v8 L=0.7 W=2.53 nf=1 ad='int((1 + 1)/2) * 2.53 / 1 * 0.29' as='int((1 + 2)/2) * 2.53 / 1 * 0.29'
+ pd='2*int((1 + 1)/2) * (2.53 / 1 + 0.29)' ps='2*int((1 + 2)/2) * (2.53 / 1 + 0.29)' nrd='0.29 / 2.53 ' nrs='0.29 / 2.53 ' sa=0
+ sb=0 sd=0 mult=1 m=1
I0 Vc VSS 5.42u
XM3 Vx Vx VDD VDD sky130_fd_pr__pfet_01v8 L=0.9 W=1.43 nf=1 ad='int((1 + 1)/2) * 1.43 / 1 * 0.29' as='int((1 + 2)/2) * 1.43 / 1 * 0.29'
+ pd='2*int((1 + 1)/2) * (1.43 / 1 + 0.29)' ps='2*int((1 + 2)/2) * (1.43 / 1 + 0.29)' nrd='0.29 / 1.43 ' nrs='0.29 / 1.43 ' sa=0
+ sb=0 sd=0 mult=1 m=1
XM4 Vout Vx VDD VDD sky130_fd_pr__pfet_01v8 L=0.9 W=1.43 nf=1 ad='int((1 + 1)/2) * 1.43 / 1 * 0.29' as='int((1 + 2)/2) * 1.43 / 1 * 0.29'
+ pd='2*int((1 + 1)/2) * (1.43 / 1 + 0.29)' ps='2*int((1 + 2)/2) * (1.43 / 1 + 0.29)' nrd='0.29 / 1.43 ' nrs='0.29 / 1.43 ' sa=0
+ sb=0 sd=0 mult=1 m=1
.ends
