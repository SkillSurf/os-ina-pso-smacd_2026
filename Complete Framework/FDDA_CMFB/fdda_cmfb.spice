* FDDA (Auto-Generated)
.subckt FDDA V_PP V_PN V_NP V_NN VDD V_CMFB VSS V_OP V_ON
XMP1 net5 V_PP net1 net1 sky130_fd_pr__pfet_01v8 L=0.16 W=1.3903 nf=1 ad='int((1 + 1)/2) * 1.3903 / 1 * 0.29' as='int((1 + 2)/2) * 1.3903 / 1 * 0.29'
+ pd='2*int((1 + 1)/2) * (1.3903 / 1 + 0.29)' ps='2*int((1 + 2)/2) * (1.3903 / 1 + 0.29)' nrd='0.29 / 1.3903 ' nrs='0.29 / 1.3903 ' sa=0
+ sb=0 sd=0 mult=1 m=1
XMP2 net6 V_PN net1 net1 sky130_fd_pr__pfet_01v8 L=0.16 W=1.3903 nf=1 ad='int((1 + 1)/2) * 1.3903 / 1 * 0.29' as='int((1 + 2)/2) * 1.3903 / 1 * 0.29'
+ pd='2*int((1 + 1)/2) * (1.3903 / 1 + 0.29)' ps='2*int((1 + 2)/2) * (1.3903 / 1 + 0.29)' nrd='0.29 / 1.3903 ' nrs='0.29 / 1.3903 ' sa=0
+ sb=0 sd=0 mult=1 m=1
XMP3 net6 V_NP net2 net2 sky130_fd_pr__pfet_01v8 L=0.16 W=1.3903 nf=1 ad='int((1 + 1)/2) * 1.3903 / 1 * 0.29' as='int((1 + 2)/2) * 1.3903 / 1 * 0.29'
+ pd='2*int((1 + 1)/2) * (1.3903 / 1 + 0.29)' ps='2*int((1 + 2)/2) * (1.3903 / 1 + 0.29)' nrd='0.29 / 1.3903 ' nrs='0.29 / 1.3903 ' sa=0
+ sb=0 sd=0 mult=1 m=1
XMP4 net5 V_NN net2 net2 sky130_fd_pr__pfet_01v8 L=0.16 W=1.3903 nf=1 ad='int((1 + 1)/2) * 1.3903 / 1 * 0.29' as='int((1 + 2)/2) * 1.3903 / 1 * 0.29'
+ pd='2*int((1 + 1)/2) * (1.3903 / 1 + 0.29)' ps='2*int((1 + 2)/2) * (1.3903 / 1 + 0.29)' nrd='0.29 / 1.3903 ' nrs='0.29 / 1.3903 ' sa=0
+ sb=0 sd=0 mult=1 m=1
XMP5 net3 V_CMFB VDD VDD sky130_fd_pr__pfet_01v8 L=3.0 W=29.9652 nf=1 ad='int((1 + 1)/2) * 29.9652 / 1 * 0.29' as='int((1 + 2)/2) * 29.9652 / 1 * 0.29'
+ pd='2*int((1 + 1)/2) * (29.9652 / 1 + 0.29)' ps='2*int((1 + 2)/2) * (29.9652 / 1 + 0.29)' nrd='0.29 / 29.9652 ' nrs='0.29 / 29.9652 ' sa=0
+ sb=0 sd=0 mult=1 m=1
XMP6 net4 V_CMFB VDD VDD sky130_fd_pr__pfet_01v8 L=3.0 W=29.9652 nf=1 ad='int((1 + 1)/2) * 29.9652 / 1 * 0.29' as='int((1 + 2)/2) * 29.9652 / 1 * 0.29'
+ pd='2*int((1 + 1)/2) * (29.9652 / 1 + 0.29)' ps='2*int((1 + 2)/2) * (29.9652 / 1 + 0.29)' nrd='0.29 / 29.9652 ' nrs='0.29 / 29.9652 ' sa=0
+ sb=0 sd=0 mult=1 m=1
XMP7 V_ON V_B4 net3 net3 sky130_fd_pr__pfet_01v8 L=0.16 W=30.1064 nf=1 ad='int((1 + 1)/2) * 30.1064 / 1 * 0.29' as='int((1 + 2)/2) * 30.1064 / 1 * 0.29'
+ pd='2*int((1 + 1)/2) * (30.1064 / 1 + 0.29)' ps='2*int((1 + 2)/2) * (30.1064 / 1 + 0.29)' nrd='0.29 / 30.1064 ' nrs='0.29 / 30.1064 ' sa=0
+ sb=0 sd=0 mult=1 m=1
XMP8 V_OP V_B4 net4 net4 sky130_fd_pr__pfet_01v8 L=0.16 W=30.1064 nf=1 ad='int((1 + 1)/2) * 30.1064 / 1 * 0.29' as='int((1 + 2)/2) * 30.1064 / 1 * 0.29'
+ pd='2*int((1 + 1)/2) * (30.1064 / 1 + 0.29)' ps='2*int((1 + 2)/2) * (30.1064 / 1 + 0.29)' nrd='0.29 / 30.1064 ' nrs='0.29 / 30.1064 ' sa=0
+ sb=0 sd=0 mult=1 m=1
XMP11 net1 V_B1 VDD VDD sky130_fd_pr__pfet_01v8 L=0.18 W=10.2205 nf=1 ad='int((1 + 1)/2) * 10.2205 / 1 * 0.29' as='int((1 + 2)/2) * 10.2205 / 1 * 0.29'
+ pd='2*int((1 + 1)/2) * (10.2205 / 1 + 0.29)' ps='2*int((1 + 2)/2) * (10.2205 / 1 + 0.29)' nrd='0.29 / 10.2205 ' nrs='0.29 / 10.2205 ' sa=0
+ sb=0 sd=0 mult=1 m=1
XMP12 net2 V_B1 VDD VDD sky130_fd_pr__pfet_01v8 L=0.18 W=10.2205 nf=1 ad='int((1 + 1)/2) * 10.2205 / 1 * 0.29' as='int((1 + 2)/2) * 10.2205 / 1 * 0.29'
+ pd='2*int((1 + 1)/2) * (10.2205 / 1 + 0.29)' ps='2*int((1 + 2)/2) * (10.2205 / 1 + 0.29)' nrd='0.29 / 10.2205 ' nrs='0.29 / 10.2205 ' sa=0
+ sb=0 sd=0 mult=1 m=1
XMN3 V_ON V_B3 net5 net5 sky130_fd_pr__nfet_01v8 L=1.0 W=22.0275 nf=1 ad='int((1 + 1)/2) * 22.0275 / 1 * 0.29' as='int((1 + 2)/2) * 22.0275 / 1 * 0.29'
+ pd='2*int((1 + 1)/2) * (22.0275 / 1 + 0.29)' ps='2*int((1 + 2)/2) * (22.0275 / 1 + 0.29)' nrd='0.29 / 22.0275 ' nrs='0.29 / 22.0275 ' sa=0
+ sb=0 sd=0 mult=1 m=1
XMN4 V_OP V_B3 net6 net6 sky130_fd_pr__nfet_01v8 L=1.0 W=22.0275 nf=1 ad='int((1 + 1)/2) * 22.0275 / 1 * 0.29' as='int((1 + 2)/2) * 22.0275 / 1 * 0.29'
+ pd='2*int((1 + 1)/2) * (22.0275 / 1 + 0.29)' ps='2*int((1 + 2)/2) * (22.0275 / 1 + 0.29)' nrd='0.29 / 22.0275 ' nrs='0.29 / 22.0275 ' sa=0
+ sb=0 sd=0 mult=1 m=1
XMN9 net5 V_B2 VSS VSS sky130_fd_pr__nfet_01v8 L=0.2 W=0.4486 nf=1 ad='int((1 + 1)/2) * 0.4486 / 1 * 0.29' as='int((1 + 2)/2) * 0.4486 / 1 * 0.29'
+ pd='2*int((1 + 1)/2) * (0.4486 / 1 + 0.29)' ps='2*int((1 + 2)/2) * (0.4486 / 1 + 0.29)' nrd='0.29 / 0.4486 ' nrs='0.29 / 0.4486 ' sa=0
+ sb=0 sd=0 mult=1 m=1
XMN10 net6 V_B2 VSS VSS sky130_fd_pr__nfet_01v8 L=0.2 W=0.4486 nf=1 ad='int((1 + 1)/2) * 0.4486 / 1 * 0.29' as='int((1 + 2)/2) * 0.4486 / 1 * 0.29'
+ pd='2*int((1 + 1)/2) * (0.4486 / 1 + 0.29)' ps='2*int((1 + 2)/2) * (0.4486 / 1 + 0.29)' nrd='0.29 / 0.4486 ' nrs='0.29 / 0.4486 ' sa=0
+ sb=0 sd=0 mult=1 m=1
V4 V_B4 VSS 0.4955
V3 V_B3 VSS 0.9474
V2 V_B2 VSS 0.9989
V1 V_B1 VSS 0.8926
.ends

* CMFB (Auto-Generated)
.subckt CMFB V_CMFB V_OP V_ON VSS VDD
XMN1 net1 V_OP net2 net2 sky130_fd_pr__nfet_01v8 L=1.0 W=60.7871 nf=1 ad='int((1 + 1)/2) * 60.7871 / 1 * 0.29' as='int((1 + 2)/2) * 60.7871 / 1 * 0.29'
+ pd='2*int((1 + 1)/2) * (60.7871 / 1 + 0.29)' ps='2*int((1 + 2)/2) * (60.7871 / 1 + 0.29)' nrd='0.29 / 60.7871 ' nrs='0.29 / 60.7871 ' sa=0
+ sb=0 sd=0 mult=1 m=1
XMN2 V_CMFB V_CM net2 net2 sky130_fd_pr__nfet_01v8 L=1.0 W=60.7871 nf=1 ad='int((1 + 1)/2) * 60.7871 / 1 * 0.29' as='int((1 + 2)/2) * 60.7871 / 1 * 0.29'
+ pd='2*int((1 + 1)/2) * (60.7871 / 1 + 0.29)' ps='2*int((1 + 2)/2) * (60.7871 / 1 + 0.29)' nrd='0.29 / 60.7871 ' nrs='0.29 / 60.7871 ' sa=0
+ sb=0 sd=0 mult=1 m=1
XMN7 net2 V_B2 VSS VSS sky130_fd_pr__nfet_01v8 L=0.2 W=0.4486 nf=1 ad='int((1 + 1)/2) * 0.4486 / 1 * 0.29' as='int((1 + 2)/2) * 0.4486 / 1 * 0.29'
+ pd='2*int((1 + 1)/2) * (0.4486 / 1 + 0.29)' ps='2*int((1 + 2)/2) * (0.4486 / 1 + 0.29)' nrd='0.29 / 0.4486 ' nrs='0.29 / 0.4486 ' sa=0
+ sb=0 sd=0 mult=1 m=1
XMN6 net4 V_ON net3 net3 sky130_fd_pr__nfet_01v8 L=1.0 W=60.7871 nf=1 ad='int((1 + 1)/2) * 60.7871 / 1 * 0.29' as='int((1 + 2)/2) * 60.7871 / 1 * 0.29'
+ pd='2*int((1 + 1)/2) * (60.7871 / 1 + 0.29)' ps='2*int((1 + 2)/2) * (60.7871 / 1 + 0.29)' nrd='0.29 / 60.7871 ' nrs='0.29 / 60.7871 ' sa=0
+ sb=0 sd=0 mult=1 m=1
XMN5 V_CMFB V_CM net3 net3 sky130_fd_pr__nfet_01v8 L=1.0 W=60.7871 nf=1 ad='int((1 + 1)/2) * 60.7871 / 1 * 0.29' as='int((1 + 2)/2) * 60.7871 / 1 * 0.29'
+ pd='2*int((1 + 1)/2) * (60.7871 / 1 + 0.29)' ps='2*int((1 + 2)/2) * (60.7871 / 1 + 0.29)' nrd='0.29 / 60.7871 ' nrs='0.29 / 60.7871 ' sa=0
+ sb=0 sd=0 mult=1 m=1
XMN8 net3 V_B2 VSS VSS sky130_fd_pr__nfet_01v8 L=0.2 W=0.4486 nf=1 ad='int((1 + 1)/2) * 0.4486 / 1 * 0.29' as='int((1 + 2)/2) * 0.4486 / 1 * 0.29'
+ pd='2*int((1 + 1)/2) * (0.4486 / 1 + 0.29)' ps='2*int((1 + 2)/2) * (0.4486 / 1 + 0.29)' nrd='0.29 / 0.4486 ' nrs='0.29 / 0.4486 ' sa=0
+ sb=0 sd=0 mult=1 m=1
XMP9 net1 net1 VDD VDD sky130_fd_pr__pfet_01v8 L=3.0 W=59.4935/2 nf=1 ad='int((1 + 1)/2) * 59.4935/2 / 1 * 0.29' as='int((1 + 2)/2) * 59.4935/2 / 1 * 0.29'
+ pd='2*int((1 + 1)/2) * (59.4935/2 / 1 + 0.29)' ps='2*int((1 + 2)/2) * (59.4935/2 / 1 + 0.29)' nrd='0.29 / 59.4935/2 ' nrs='0.29 / 59.4935/2 '
+ sa=0 sb=0 sd=0 mult=1 m=1
XMP13 V_CMFB V_CMFB VDD VDD sky130_fd_pr__pfet_01v8 L=3.0 W=59.4935 nf=1 ad='int((1 + 1)/2) * 59.4935 / 1 * 0.29' as='int((1 + 2)/2) * 59.4935 / 1 * 0.29'
+ pd='2*int((1 + 1)/2) * (59.4935 / 1 + 0.29)' ps='2*int((1 + 2)/2) * (59.4935 / 1 + 0.29)' nrd='0.29 / 59.4935 ' nrs='0.29 / 59.4935 ' sa=0
+ sb=0 sd=0 mult=1 m=1
XMP10 net4 net4 VDD VDD sky130_fd_pr__pfet_01v8 L=3.0 W=59.4935/2 nf=1 ad='int((1 + 1)/2) * 59.4935/2 / 1 * 0.29' as='int((1 + 2)/2) * 59.4935/2 / 1 * 0.29'
+ pd='2*int((1 + 1)/2) * (59.4935/2 / 1 + 0.29)' ps='2*int((1 + 2)/2) * (59.4935/2 / 1 + 0.29)' nrd='0.29 / 59.4935/2 ' nrs='0.29 / 59.4935/2 '
+ sa=0 sb=0 sd=0 mult=1 m=1
V2 V_B2 VSS 0.9989
V1 V_CM VSS 0.9
.ends
