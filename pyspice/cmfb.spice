*CMFB auto generated
.subckt CMFB VDD Vop Von Vcm Vb2 Vcmfb

XMP9 n1 n1 VDD VDD sky130_fd_pr__pfet_01v8 L=1 W=88.0 nf=1 ad='int((1+1)/2) * 88.0/1 * 0.29' as='int((1+2)/2) * 88.0/1 * 0.29' pd='2*int((1+1)/2) * (88.0/1 + 0.29)' ps='2*int((1+2)/2) * (88.0/1 + 0.29)' nrd='0.29 / 88.0' nrs='0.29 / 88.0' sa=0 sb=0 sd=0
XMP10 n2 n2 VDD VDD sky130_fd_pr__pfet_01v8 L=1 W=88.0 nf=1 ad='int((1+1)/2) * 88.0/1 * 0.29' as='int((1+2)/2) * 88.0/1 * 0.29' pd='2*int((1+1)/2) * (88.0/1 + 0.29)' ps='2*int((1+2)/2) * (88.0/1 + 0.29)' nrd='0.29 / 88.0' nrs='0.29 / 88.0' sa=0 sb=0 sd=0
XMP13 Vcmfb Vcmfb VDD VDD sky130_fd_pr__pfet_01v8 L=1 W=88.0 nf=1 ad='int((1+1)/2) * 88.0/1 * 0.29' as='int((1+2)/2) * 88.0/1 * 0.29' pd='2*int((1+1)/2) * (88.0/1 + 0.29)' ps='2*int((1+2)/2) * (88.0/1 + 0.29)' nrd='0.29 / 88.0' nrs='0.29 / 88.0' sa=0 sb=0 sd=0
XMN1 n1 Vop  nt1 0 sky130_fd_pr__nfet_01v8 L=1 W=14.0 nf=1 ad='int((1+1)/2) * 14.0/1 * 0.29' as='int((1+2)/2) * 14.0/1 * 0.29' pd='2*int((1+1)/2) * (14.0/1 + 0.29)' ps='2*int((1+2)/2) * (14.0/1 + 0.29)' nrd='0.29 / 14.0' nrs='0.29 / 14.0' sa=0 sb=0 sd=0
XMN2 Vcmfb Vcm  nt1 0 sky130_fd_pr__nfet_01v8 L=1 W=14.0 nf=1 ad='int((1+1)/2) * 14.0/1 * 0.29' as='int((1+2)/2) * 14.0/1 * 0.29' pd='2*int((1+1)/2) * (14.0/1 + 0.29)' ps='2*int((1+2)/2) * (14.0/1 + 0.29)' nrd='0.29 / 14.0' nrs='0.29 / 14.0' sa=0 sb=0 sd=0
XMN5 Vcmfb Vcm  nt2 0 sky130_fd_pr__nfet_01v8 L=1 W=14.0 nf=1 ad='int((1+1)/2) * 14.0/1 * 0.29' as='int((1+2)/2) * 14.0/1 * 0.29' pd='2*int((1+1)/2) * (14.0/1 + 0.29)' ps='2*int((1+2)/2) * (14.0/1 + 0.29)' nrd='0.29 / 14.0' nrs='0.29 / 14.0' sa=0 sb=0 sd=0
XMN6 n2 Von  nt2 0 sky130_fd_pr__nfet_01v8 L=1 W=14.0 nf=1 ad='int((1+1)/2) * 14.0/1 * 0.29' as='int((1+2)/2) * 14.0/1 * 0.29' pd='2*int((1+1)/2) * (14.0/1 + 0.29)' ps='2*int((1+2)/2) * (14.0/1 + 0.29)' nrd='0.29 / 14.0' nrs='0.29 / 14.0' sa=0 sb=0 sd=0
XMN7 nt1 Vb2 0 0 sky130_fd_pr__nfet_01v8 L=1 W=28.0 nf=1 ad='int((1+1)/2) * 28.0/1 * 0.29' as='int((1+2)/2) * 28.0/1 * 0.29' pd='2*int((1+1)/2) * (28.0/1 + 0.29)' ps='2*int((1+2)/2) * (28.0/1 + 0.29)' nrd='0.29 / 28.0' nrs='0.29 / 28.0' sa=0 sb=0 sd=0
XMN8 nt2 Vb2 0 0 sky130_fd_pr__nfet_01v8 L=1 W=28.0 nf=1 ad='int((1+1)/2) * 28.0/1 * 0.29' as='int((1+2)/2) * 28.0/1 * 0.29' pd='2*int((1+1)/2) * (28.0/1 + 0.29)' ps='2*int((1+2)/2) * (28.0/1 + 0.29)' nrd='0.29 / 28.0' nrs='0.29 / 28.0' sa=0 sb=0 sd=0

.ends CMFB
