*Bias circuit auto generated
.subckt BIAS VDD Vb1 Vb2 Vb3 Vb4

IREF VDD n1 2.5uA
XMN11 n1 n1 0 0 sky130_fd_pr__nfet_01v8 L=2 W=5
XMN12 Vb1 n1 0 0 sky130_fd_pr__nfet_01v8 L=2 W=5

XMP14 Vb1 Vb1 VDD VDD sky130_fd_pr__pfet_01v8 L=2 W=35
XMP15 Vb3 Vb1 VDD VDD sky130_fd_pr__pfet_01v8 L=2 W=35
XMP16 Vb2 Vb1 VDD VDD sky130_fd_pr__pfet_01v8 L=2 W=35
XMP17 Vb4 Vb4 VDD VDD sky130_fd_pr__pfet_01v8 L=3 W=5

XMN13 Vb3 Vb3 0 0 sky130_fd_pr__nfet_01v8 L=4 W=1
XMN14 Vb2 Vb2 0 0 sky130_fd_pr__nfet_01v8 L=2 W=5
XMN15 Vb4 Vb2 0 0 sky130_fd_pr__nfet_01v8 L=2 W=5

.ends BIAS
