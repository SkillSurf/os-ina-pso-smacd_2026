* FDDA (Auto-generated)
.subckt FDDA VDD Vpp Vpn Vnp Vnn Vcmfb Vb1 Vb2 Vb3 Vb4 Von Vop
Vmeas1 net11 net1 0V
Vmeas2 net5 net9 0V
Vmeas3 net6 net10 0V
Vmeas4 net12 net2 0V
Vmeas5 net13 net9 0V
XMP1 net5 Vpp net1 VDD sky130_fd_pr__pfet_01v8 L=1 W=88.0 nf=1 ad='int((1+1)/2) * 88.0/1 * 0.29' as='int((1+2)/2) * 88.0/1 * 0.29' pd='2*int((1+1)/2) * (88.0/1 + 0.29)' ps='2*int((1+2)/2) * (88.0/1 + 0.29)' nrd='0.29 / 88.0' nrs='0.29 / 88.0' sa=0 sb=0 sd=0
+ mult=1 m=1
XMP2 net6 Vpn net1 VDD sky130_fd_pr__pfet_01v8 L=1 W=88.0 nf=1 ad='int((1+1)/2) * 88.0/1 * 0.29' as='int((1+2)/2) * 88.0/1 * 0.29' pd='2*int((1+1)/2) * (88.0/1 + 0.29)' ps='2*int((1+2)/2) * (88.0/1 + 0.29)' nrd='0.29 / 88.0' nrs='0.29 / 88.0' sa=0 sb=0 sd=0
+ mult=1 m=1
XMP3 net6 Vnp net2 VDD sky130_fd_pr__pfet_01v8 L=1 W=88.0 nf=1 ad='int((1+1)/2) * 88.0/1 * 0.29' as='int((1+2)/2) * 88.0/1 * 0.29' pd='2*int((1+1)/2) * (88.0/1 + 0.29)' ps='2*int((1+2)/2) * (88.0/1 + 0.29)' nrd='0.29 / 88.0' nrs='0.29 / 88.0' sa=0 sb=0 sd=0
+ mult=1 m=1
XMP4 net5 Vnn net2 VDD sky130_fd_pr__pfet_01v8 L=1 W=88.0 nf=1 ad='int((1+1)/2) * 88.0/1 * 0.29' as='int((1+2)/2) * 88.0/1 * 0.29' pd='2*int((1+1)/2) * (88.0/1 + 0.29)' ps='2*int((1+2)/2) * (88.0/1 + 0.29)' nrd='0.29 / 88.0' nrs='0.29 / 88.0' sa=0 sb=0 sd=0
+ mult=1 m=1
XMP5 net3 Vcmfb VDD VDD sky130_fd_pr__pfet_01v8 L=1 W=88.0 nf=1 ad='int((1+1)/2) * 88.0/1 * 0.29' as='int((1+2)/2) * 88.0/1 * 0.29' pd='2*int((1+1)/2) * (88.0/1 + 0.29)' ps='2*int((1+2)/2) * (88.0/1 + 0.29)' nrd='0.29 / 88.0' nrs='0.29 / 88.0' sa=0 sb=0 sd=0
+ mult=1 m=1
XMP6 net4 Vcmfb VDD VDD sky130_fd_pr__pfet_01v8 L=1 W=88.0 nf=1 ad='int((1+1)/2) * 88.0/1 * 0.29' as='int((1+2)/2) * 88.0/1 * 0.29' pd='2*int((1+1)/2) * (88.0/1 + 0.29)' ps='2*int((1+2)/2) * (88.0/1 + 0.29)' nrd='0.29 / 88.0' nrs='0.29 / 88.0' sa=0 sb=0 sd=0
+ mult=1 m=1
XMP7 Von Vb4 net3 VDD sky130_fd_pr__pfet_01v8 L=1 W=88.0 nf=1 ad='int((1+1)/2) * 88.0/1 * 0.29' as='int((1+2)/2) * 88.0/1 * 0.29' pd='2*int((1+1)/2) * (88.0/1 + 0.29)' ps='2*int((1+2)/2) * (88.0/1 + 0.29)' nrd='0.29 / 88.0' nrs='0.29 / 88.0' sa=0 sb=0 sd=0
+ mult=1 m=1
XMP8 Vop Vb4 net4 VDD sky130_fd_pr__pfet_01v8 L=1 W=88.0 nf=1 ad='int((1+1)/2) * 88.0/1 * 0.29' as='int((1+2)/2) * 88.0/1 * 0.29' pd='2*int((1+1)/2) * (88.0/1 + 0.29)' ps='2*int((1+2)/2) * (88.0/1 + 0.29)' nrd='0.29 / 88.0' nrs='0.29 / 88.0' sa=0 sb=0 sd=0
+ mult=1 m=1
XMP11 net11 Vb1 VDD VDD sky130_fd_pr__pfet_01v8 L=1 W=88.0 nf=1 ad='int((1+1)/2) * 88.0/1 * 0.29' as='int((1+2)/2) * 88.0/1 * 0.29' pd='2*int((1+1)/2) * (88.0/1 + 0.29)' ps='2*int((1+2)/2) * (88.0/1 + 0.29)' nrd='0.29 / 88.0' nrs='0.29 / 88.0' sa=0 sb=0 sd=0
+ mult=1 m=1
XMP12 net12 Vb1 VDD VDD sky130_fd_pr__pfet_01v8 L=1 W=88.0 nf=1 ad='int((1+1)/2) * 88.0/1 * 0.29' as='int((1+2)/2) * 88.0/1 * 0.29' pd='2*int((1+1)/2) * (88.0/1 + 0.29)' ps='2*int((1+2)/2) * (88.0/1 + 0.29)' nrd='0.29 / 88.0' nrs='0.29 / 88.0' sa=0 sb=0 sd=0
+ mult=1 m=1
XMN3 Von Vb3 net13 0 sky130_fd_pr__nfet_01v8 L=1 W=14.0 nf=1 ad='int((1+1)/2) * 14.0/1 * 0.29' as='int((1+2)/2) * 14.0/1 * 0.29' pd='2*int((1+1)/2) * (14.0/1 + 0.29)' ps='2*int((1+2)/2) * (14.0/1 + 0.29)' nrd='0.29 / 14.0' nrs='0.29 / 14.0' sa=0 sb=0 sd=0
+ mult=1 m=1
XMN4 Vop Vb3 net6 0 sky130_fd_pr__nfet_01v8 L=1 W=14.0 nf=1 ad='int((1+1)/2) * 14.0/1 * 0.29' as='int((1+2)/2) * 14.0/1 * 0.29' pd='2*int((1+1)/2) * (14.0/1 + 0.29)' ps='2*int((1+2)/2) * (14.0/1 + 0.29)' nrd='0.29 / 14.0' nrs='0.29 / 14.0' sa=0 sb=0 sd=0
+ mult=1 m=1
XMN9 net9 Vb2 0 0 sky130_fd_pr__nfet_01v8 L=1 W=28.0 nf=1 ad='int((1+1)/2) * 28.0/1 * 0.29' as='int((1+2)/2) * 28.0/1 * 0.29' pd='2*int((1+1)/2) * (28.0/1 + 0.29)' ps='2*int((1+2)/2) * (28.0/1 + 0.29)' nrd='0.29 / 28.0' nrs='0.29 / 28.0' sa=0 sb=0 sd=0
+ mult=1 m=1
XMN10 net10 Vb2 0 0 sky130_fd_pr__nfet_01v8 L=1 W=28.0 nf=1 ad='int((1+1)/2) * 28.0/1 * 0.29' as='int((1+2)/2) * 28.0/1 * 0.29' pd='2*int((1+1)/2) * (28.0/1 + 0.29)' ps='2*int((1+2)/2) * (28.0/1 + 0.29)' nrd='0.29 / 28.0' nrs='0.29 / 28.0' sa=0 sb=0 sd=0
+ mult=1 m=1

.ends
